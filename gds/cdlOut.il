cdlOutKeys = list(nil
	'simLibName		"opus"
	'simCellName		"latch.cdl"
	'simViewName		"schematic"
	'hnlNetlistFileName	"netlist"
	'simRunDir		"."
	'shortRES		2000.000000
	'resistorCheck		"none"
	'capacitorCheck		"none"
	'diodeCheck		'(t t)
        'displayPinInfo         'nil
)
